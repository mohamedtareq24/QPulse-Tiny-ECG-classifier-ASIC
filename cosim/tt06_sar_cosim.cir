* TT06 SAR ADC Cosimulation Wrapper
* For use with spicebind VPI mixed-signal cosimulator
*
* DUT:  tt_um_TT06_SAR_wulffern (post-layout extracted netlist)
*        8-bit SAR ADC in SKY130NM
* Inputs:  ua[1]=SAR_IP (positive), ua[0]=SAR_IN (negative)
*          clk (4 MHz), rst_n, ena, ui_in[0] (enable/start)
* Outputs: uo_out[7:0] = 8-bit code, uio_out[0] = DONE
*
* Port-name matching with Verilog shell (tt_um_TT06_SAR_wulffern.v):
*   Verilog port  | SPICE source (name-1 = port name) | top-level node
*   ua_1          | Vua_1                              | ua_1
*   ua_0          | Vua_0                              | ua_0
*   clk           | Vclk                               | clk
*   rst_n         | Vrst_n                             | rst_n
*   ena           | Vena                               | ena
*   ui_in_0       | Vui_in_0                           | ui_in_0
*   uo_out[7:0]   | (read via ngGet_Vec_Info)          | uo_out[7..0]
*   uio_out[7:0]  | (read via ngGet_Vec_Info)          | uio_out[7..0]

* === SKY130A PDK Models (typical corner) ===
.lib /home/zkp_egy2/nasser_chip_top/nasser_chip/dependencies/pdks/volare/sky130/versions/af3485525297d5cbe93c129ea853da2d588fac41/sky130A/libs.tech/ngspice/sky130.lib.spice tt

* === DUT: post-layout extracted netlist ===
.include ../spi/tt_um_TT06_SAR_wulffern_lpe.spi

* === Simulation options ===
.option TEMP=27
.option RELTOL=0.03
.option ABSTOL=1e-9
.option VNTOL=1e-4
.option METHOD=Gear
.option TRTOL=7

* === Power supplies ===
* VPWR = 1.8 V (sky130 nominal), VGND = 0 V (= SPICE ground)
Vpwr  VPWR 0 DC 1.8
* VGND is already global ground (node 0), but explicitly tie it for subckt port
Vgnd  VGND 0 DC 0

* ==========================================================
* === External sources: driven by spicebind from Verilog ===
* Source name minus leading 'V' must match lowercase Verilog port name
* ==========================================================

* Analog differential inputs
Vua_1   ua_1   0  0  external
Vua_0   ua_0   0  0  external

* Digital control inputs
Vclk      clk      0  0  external
Vrst_n    rst_n    0  0  external
Vena      ena      0  0  external
Vui_in_0  ui_in_0  0  0  external

* === Tie unused inputs to 0 ===
* ui_in[7:1] not driven from Verilog – tie to VGND (logic 0)
Vui_in1  ui_in_1_nc  0  DC  0
Vui_in2  ui_in_2_nc  0  DC  0
Vui_in3  ui_in_3_nc  0  DC  0
Vui_in4  ui_in_4_nc  0  DC  0
Vui_in5  ui_in_5_nc  0  DC  0
Vui_in6  ui_in_6_nc  0  DC  0
Vui_in7  ui_in_7_nc  0  DC  0

* uio_in[7:0] – bidirectional, used as inputs; tie to 0
Vuio_in0  uio_in_0_nc  0  DC  0
Vuio_in1  uio_in_1_nc  0  DC  0
Vuio_in2  uio_in_2_nc  0  DC  0
Vuio_in3  uio_in_3_nc  0  DC  0
Vuio_in4  uio_in_4_nc  0  DC  0
Vuio_in5  uio_in_5_nc  0  DC  0
Vuio_in6  uio_in_6_nc  0  DC  0
Vuio_in7  uio_in_7_nc  0  DC  0

* ua[7:2] – unused analog pins; tie to mid-supply (0.9 V) to avoid floating
Vua2  ua_2_nc  0  DC  0.9
Vua3  ua_3_nc  0  DC  0.9
Vua4  ua_4_nc  0  DC  0.9
Vua5  ua_5_nc  0  DC  0.9
Vua6  ua_6_nc  0  DC  0.9
Vua7  ua_7_nc  0  DC  0.9

* ==========================================================
* === DUT instantiation (positional, matching .subckt order)
* .subckt tt_um_TT06_SAR_wulffern
*   VPWR VGND
*   ui_in[7..0]   (8, MSB first)
*   uo_out[7..0]  (8, MSB first) -- observed by spicebind as uo_out[7..0]
*   uio_in[7..0]  (8, MSB first)
*   uio_out[7..0] (8, MSB first) -- observed by spicebind as uio_out[7..0]
*   uio_oe[7..0]  (8, MSB first) -- DUT outputs, not read by Verilog
*   ua[7..0]      (8, MSB first) -- ua[1]=SAR_IP, ua[0]=SAR_IN
*   ena clk rst_n
* ==========================================================
Xdut  VPWR VGND
+  ui_in_7_nc  ui_in_6_nc  ui_in_5_nc  ui_in_4_nc
+  ui_in_3_nc  ui_in_2_nc  ui_in_1_nc  ui_in_0
+  uo_out[7]  uo_out[6]  uo_out[5]  uo_out[4]
+  uo_out[3]  uo_out[2]  uo_out[1]  uo_out[0]
+  uio_in_7_nc  uio_in_6_nc  uio_in_5_nc  uio_in_4_nc
+  uio_in_3_nc  uio_in_2_nc  uio_in_1_nc  uio_in_0_nc
+  uio_out[7]  uio_out[6]  uio_out[5]  uio_out[4]
+  uio_out[3]  uio_out[2]  uio_out[1]  uio_out[0]
+  uio_oe_7_nc  uio_oe_6_nc  uio_oe_5_nc  uio_oe_4_nc
+  uio_oe_3_nc  uio_oe_2_nc  uio_oe_1_nc  uio_oe_0_nc
+  ua_7_nc  ua_6_nc  ua_5_nc  ua_4_nc  ua_3_nc  ua_2_nc  ua_1  ua_0
+  ena  clk  rst_n
+  tt_um_TT06_SAR_wulffern

* === Convergence fix for LPE floating nodes ===
* The post-layout netlist has ~300 cap-only floating nodes (marked **FLOATING).
* RSHUNT adds a 10 GΩ shunt from every node to ground so the DC matrix is
* non-singular; its effect on signal nodes is negligible (<<1 fA leakage).
.option RSHUNT=1e10

* === Transient analysis ===
* 50 ns max step, 50 us total (at 4 MHz, 8-bit SAR needs ~9 cycles = 2.25 us;
* give 10 us per phase to capture multiple conversions)
.tran 50ns 210us 0 50ns

.end
